`include "disciplines.vams"

module resistor(p, n);
    parameter real R = 1.0k from (0:inf);
    inout p, n;
    electrical p, n;
    analog begin
        I(p, n) <+ V(p, n) / R;
    end
endmodule
